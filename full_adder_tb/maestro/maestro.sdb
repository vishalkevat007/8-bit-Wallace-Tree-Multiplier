ADE simulation setup
Run mode: Single Run, Sweeps and Corners
Tests:
  Project_full_adder_tb_1: Project/full_adder_tb/schematic, simulator spectre
