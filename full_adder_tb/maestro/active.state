ADE simulation setup
Test Project_full_adder_tb_1: Project/full_adder_tb/schematic, simulator spectre
  Models: /package/eda/cadence/gpdk045/gpdk045_v_6_0/gpdk045/../models/spectre/gpdk045.scs[tt]
  Temperature: 27
  Stimulus A: voltage pulse val0=0 val1=1.1 period=2n rise=50p fall=50p width=1n
  Stimulus B: voltage dc dc=1.1
  Stimulus Ci: voltage dc dc=0
  Stimulus vdd!: voltage dc dc=1.1
  Analysis tran: stop=10n
  Output delay(?wf1 VT("/A") ?value1 0.55 ?edge1 "rising" ?nth1 1 ?td1 0.0 ?tol1 nil ?wf2 VT("/Sum") ?value2 0.55 ?edge2 "falling" ?nth2 1 ?tol2 nil ?td2 nil ?stop nil ?multiple nil)
  Signals: /A, /B, /Ci, /Sum
Run mode: Single Run, Sweeps and Corners
