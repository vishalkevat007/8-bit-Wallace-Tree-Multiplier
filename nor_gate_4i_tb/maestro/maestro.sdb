ADE simulation setup
Run mode: Single Run, Sweeps and Corners
Tests:
  Project_nor_gate_4i_tb_1: Project/nor_gate_4i_tb/schematic, simulator spectre
    Outputs: tphl_D_rises_Out_falls; tplh_D_falls_Out_rises
