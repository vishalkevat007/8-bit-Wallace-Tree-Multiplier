ADE simulation setup
Run mode: Single Run, Sweeps and Corners
Tests:
  Project_mux_2i_tb_1: Project/mux_2i_tb/schematic, simulator spectre
