ADE simulation setup
Test Project_mux_2i_tb_1: Project/mux_2i_tb/schematic, simulator spectre
  Models: /package/eda/cadence/gpdk045/gpdk045_v_6_0/gpdk045/../models/spectre/gpdk045.scs[tt]
  Temperature: 27
  Stimulus A: voltage bit val1=1.1 val0=0 rise=30p fall=30p period=2n data=1011001
  Stimulus B: voltage bit val1=1.1 val0=0 rise=30p fall=30p period=2n data=11010101
  Stimulus S: voltage bit val1=1.1 val0=0 rise=30p fall=30p period=2n data=000111
  Stimulus Vdd: voltage dc dc=1.1
  Analysis tran: stop=20n
  Signals: /A as f, /B as B, /S as S, /Out as Out
Run mode: Single Run, Sweeps and Corners
