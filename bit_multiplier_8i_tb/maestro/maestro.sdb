ADE simulation setup
Run mode: Single Run, Sweeps and Corners
Tests:
  Project_partial_product_generator_8i_tb_1: Project/bit_multiplier_8i_tb/schematic, simulator spectre
    Outputs: /A0; /B<0:7>
