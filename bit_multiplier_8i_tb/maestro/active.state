ADE simulation setup
Test Project_partial_product_generator_8i_tb_1: Project/bit_multiplier_8i_tb/schematic, simulator spectre
  Models: /package/eda/cadence/gpdk045/gpdk045_v_6_0/gpdk045/../models/spectre/gpdk045.scs[tt]
  Temperature: 27
  Stimulus vdd!: voltage dc dc=1.1
  Stimulus A0: voltage dc dc=1.1
  Stimulus B<0>: voltage pulse dc=1.1 val0=0 val1=1.1 period=4n rise=50p fall=50p width=2n
  Stimulus B<1>: voltage pulse dc=1.1 val0=0 val1=1.1 period=4n rise=50p fall=50p width=2n
  Stimulus B<2>: voltage pulse dc=1.1 val0=0 val1=1.1 period=4n rise=50p fall=50p width=2n
  Stimulus B<3>: voltage pulse dc=1.1 val0=0 val1=1.1 period=4n rise=50p fall=50p width=2n
  Stimulus B<4>: voltage pulse dc=1.1 val0=0 val1=1.1 period=4n delay=500.0p rise=50p fall=50p width=2n
  Stimulus B<5>: voltage pulse dc=1.1 val0=0 val1=1.1 period=4n delay=500.0p rise=50p fall=50p width=2n
  Stimulus B<6>: voltage pulse dc=1.1 val0=0 val1=1.1 period=4n delay=500.0p rise=50p fall=50p width=2n
  Stimulus B<7>: voltage pulse dc=1.1 val0=0 val1=1.1 period=4n delay=500.0p rise=50p fall=50p width=2n
  Analysis tran: stop=16n
  Signals: /B<0:7>, /A0, /PP<0:7>
Run mode: Single Run, Sweeps and Corners
