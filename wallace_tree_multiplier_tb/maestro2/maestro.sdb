ADE simulation setup
Run mode: Single Run, Sweeps and Corners
Tests:
  Project_wallace_tree_multiplier_tb_1: Project/wallace_tree_multiplier_tb/config, simulator spectre
    Outputs: delay(?wf1 VT("/A<5>") ?value1 0.55 ?edge1 "rising" ?nth1 1 ?td1 0.0 ?tol1 nil ?wf2 VT("/P<8>") ?value2 0.55 ?edge2 "falling" ?nth2 1 ?tol2 nil ?td2 nil ?stop nil ?multiple nil); delay(?wf1 VT("/A<5>") ?value1 0.55 ?edge1 "falling" ?nth1 1 ?td1 0.0 ?tol1 nil ?wf2 VT("/P<8>") ?value2 0.55 ?edge2 "falling" ?nth2 1 ?tol2 nil ?td2 nil ?stop nil ?multiple nil); delay(?wf1 VT("/A<5>") ?value1 0.55 ?edge1 "falling" ?nth1 1 ?td1 0.0 ?tol1 nil ?wf2 VT("/P<9>") ?value2 0.55 ?edge2 "rising" ?nth2 1 ?tol2 nil ?td2 nil ?stop nil ?multiple nil); delay(?wf1 VT("/A<0>") ?value1 0.55 ?edge1 "rising" ?nth1 1 ?td1 0.0 ?tol1 nil ?wf2 VT("/P<9>") ?value2 0.55 ?edge2 "falling" ?nth2 1 ?tol2 nil ?td2 nil ?stop nil ?multiple nil); Product_P; Input_B; "/A<7:0>"; Energy_P8; Delay_P8_1V2; delay(?wf1 VT("/A<2>") ?value1 0.55 ?edge1 "rising" ?nth1 3 ?td1 0.0 ?tol1 nil ?wf2 VT("/P<8>") ?value2 0.5 ?edge2 "rising" ?nth2 3 ?tol2 nil ?td2 nil ?stop nil ?multiple nil); Delay_P8_1V0; delay(?wf1 VT("/A<2>") ?value1 0.55 ?edge1 "rising" ?nth1 3 ?td1 0.0 ?tol1 nil ?wf2 VT("/P<8>") ?value2 0.55 ?edge2 "rising" ?nth2 3 ?tol2 nil ?td2 nil ?stop nil ?multiple nil)
