ADE simulation setup
Test Project_wallace_tree_multiplier_tb_1: Project/wallace_tree_multiplier_tb/config, simulator spectre
  Models: /package/eda/cadence/gpdk045/gpdk045_v_6_0/gpdk045/../models/spectre/gpdk045.scs[tt]
  Temperature: 27
  Stimulus A<0>: voltage bit val1=1.1 val0=0 rise=50p fall=50p period=4n data=01110100 rpttimes=-1
  Stimulus A<1>: voltage bit val1=1.1 val0=0 rise=50p fall=50p period=4n data=01100000 rpttimes=-1
  Stimulus A<2>: voltage bit val1=1.1 val0=0 rise=50p fall=50p period=4n data=01010100 rpttimes=-1
  Stimulus A<3>: voltage bit val1=1.1 val0=0 rise=50p fall=50p period=4n data=01110101 rpttimes=-1
  Stimulus A<4>: voltage bit val1=1.1 val0=0 rise=50p fall=50p period=4n data=01100100 rpttimes=-1
  Stimulus A<5>: voltage bit val1=1.1 val0=0 rise=50p fall=50p period=4n data=01010001 rpttimes=-1
  Stimulus A<6>: voltage bit val1=1.1 val0=0 rise=50p fall=50p period=4n data=01000001 rpttimes=-1
  Stimulus A<7>: voltage bit val1=1.1 val0=0 rise=50p fall=50p period=4n data=01000100 rpttimes=-1
  Stimulus B<0>: voltage bit val1=1.1 val0=0 rise=50p fall=50p period=4n data=11100000 rpttimes=-1
  Stimulus B<1>: voltage bit val1=1.1 val0=0 rise=50p fall=50p period=4n data=11100000 rpttimes=-1
  Stimulus B<2>: voltage bit val1=1.1 val0=0 rise=50p fall=50p period=4n data=11110101 rpttimes=-1
  Stimulus B<3>: voltage bit val1=1.1 val0=0 rise=50p fall=50p period=4n data=11100101 rpttimes=-1
  Stimulus B<4>: voltage bit val1=1.1 val0=0 rise=50p fall=50p period=4n data=11110101 rpttimes=-1
  Stimulus B<5>: voltage bit val1=1.1 val0=0 rise=50p fall=50p period=4n data=11010000 rpttimes=-1
  Stimulus B<6>: voltage bit val1=1.1 val0=0 rise=50p fall=50p period=4n data=11000000 rpttimes=-1
  Stimulus B<7>: voltage bit val1=1.1 val0=0 rise=50p fall=50p period=4n data=11000101 rpttimes=-1
  Stimulus vdd!: voltage dc dc=1.1
  Analysis tran: stop=28n
  Output Delay_P8_1V0 = delay(?wf1 VT("/A<2>") ?value1 0.5 ?edge1 "rising" ?nth1 3 ?td1 0.0 ?tol1 nil ?wf2 VT("/P<8>") ?value2 0.5 ?edge2 "rising" ?nth2 3 ?tol2 nil ?td2 nil ?stop nil ?multiple nil) (unticked)
  Output Delay_P8_1V1 = delay(?wf1 VT("/A<2>") ?value1 0.55 ?edge1 "rising" ?nth1 3 ?td1 0.0 ?tol1 nil ?wf2 VT("/P<8>") ?value2 0.55 ?edge2 "rising" ?nth2 3 ?tol2 nil ?td2 nil ?stop nil ?multiple nil)
  Output Delay_P8_1V2 = delay(?wf1 VT("/A<2>") ?value1 0.6 ?edge1 "rising" ?nth1 3 ?td1 0.0 ?tol1 nil ?wf2 VT("/P<8>") ?value2 0.6 ?edge2 "rising" ?nth2 3 ?tol2 nil ?td2 nil ?stop nil ?multiple nil) (unticked)
  Output Energy_P8 = integ((IT("/I0/Vdd") * VT("/vdd!")) 2e-08 2.25e-08 " ")
  Signals: /A<7:0> as Input_A, /B<7:0> as Input_B, /vdd! as Source_Voltage, /I0/Vdd (terminal) as Source_Current, /P<15:0> as Product_P
Run mode: Single Run, Sweeps and Corners
