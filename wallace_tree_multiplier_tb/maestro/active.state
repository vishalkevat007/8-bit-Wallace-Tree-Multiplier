ADE simulation setup
Test Project_wallace_tree_multiplier_tb_1: Project/wallace_tree_multiplier_tb/config, simulator spectre
  Models: /package/eda/cadence/gpdk045/gpdk045_v_6_0/gpdk045/../models/spectre/gpdk045.scs[tt]
  Temperature: 27
  Stimulus vdd!: voltage dc dc=1.1
  Stimulus A<0>: voltage bit val1=1.1 val0=0 rise=50p fall=50p period=4n data=1011110 rpttimes=-1
  Stimulus A<1>: voltage bit val1=1.1 val0=0 rise=50p fall=50p period=4n data=1100001 rpttimes=-1
  Stimulus A<2>: voltage bit val1=1.1 val0=0 rise=50p fall=50p period=4n data=1011011 rpttimes=-1
  Stimulus A<3>: voltage bit val1=1.1 val0=0 rise=50p fall=50p period=4n data=1111001 rpttimes=-1
  Stimulus A<4>: voltage bit val1=1.1 val0=0 rise=50p fall=50p period=4n data=1101000 rpttimes=-1
  Stimulus A<5>: voltage bit val1=1.1 val0=0 rise=50p fall=50p period=4n data=1010010 rpttimes=-1
  Stimulus A<6>: voltage bit val1=1.1 val0=0 rise=50p fall=50p period=4n data=1100010 rpttimes=-1
  Stimulus A<7>: voltage bit val1=1.1 val0=0 rise=50p fall=50p period=4n data=1001010 rpttimes=-1
  Stimulus B<0>: voltage bit val1=1.1 val0=0 rise=50p fall=50p period=4n data=1010011 rpttimes=-1
  Stimulus B<1>: voltage bit val1=1.1 val0=0 rise=50p fall=50p period=4n data=1100001 rpttimes=-1
  Stimulus B<2>: voltage bit val1=1.1 val0=0 rise=50p fall=50p period=4n data=1111001 rpttimes=-1
  Stimulus B<3>: voltage bit val1=1.1 val0=0 rise=50p fall=50p period=4n data=1101000 rpttimes=-1
  Stimulus B<4>: voltage bit val1=1.1 val0=0 rise=50p fall=50p period=4n data=1011010 rpttimes=-1
  Stimulus B<5>: voltage bit val1=1.1 val0=0 rise=50p fall=50p period=4n data=1110001 rpttimes=-1
  Stimulus B<6>: voltage bit val1=1.1 val0=0 rise=50p fall=50p period=4n data=1100001 rpttimes=-1
  Stimulus B<7>: voltage bit val1=1.1 val0=0 rise=50p fall=50p period=4n data=1001010 rpttimes=-1
  Analysis tran: stop=28n
  Output Delay_P9_Schematic = delay(?wf1 VT("/A<0>") ?value1 0.55 ?edge1 "falling" ?nth1 2 ?td1 0.0 ?tol1 nil ?wf2 VT("/P<9>") ?value2 0.55 ?edge2 "rising" ?nth2 1 ?tol2 nil ?td2 nil ?stop nil ?multiple nil) (unticked)
  Output Energy_B = integ(((IT("/I0/B<0>") * VT("/B<0>")) + (IT("/I0/B<1>") * VT("/B<1>")) + (IT("/I0/B<2>") * VT("/B<2>")) + (IT("/I0/B<3>") * VT("/B<3>")) + (IT("/I0/B<4>") * VT("/B<4>")) + (IT("/I0/B<5>") * VT("/B<5>")) + (IT("/I0/B<6>") * VT("/B<6>")) + (IT("/I0/B<7>") * VT("/B<7>"))) 1.2105e-08 1.3595e-08 " ") (unticked)
  Output Energy_A = integ(((IT("/I0/A<0>") * VT("/A<0>")) + (IT("/I0/A<1>") * VT("/A<1>")) + (IT("/I0/A<2>") * VT("/A<2>")) + (IT("/I0/A<3>") * VT("/A<3>")) + (IT("/I0/A<4>") * VT("/A<4>")) + (IT("/I0/A<5>") * VT("/A<5>")) + (IT("/I0/A<6>") * VT("/A<6>")) + (IT("/I0/A<7>") * VT("/A<7>"))) 1.2105e-08 1.3595e-08 " ") (unticked)
  Output Energy_Vdd = integ((IT("/I0/Vdd") * VT("/vdd!")) 1.2105e-08 1.3595e-08 " ") (unticked)
  Output Delay_P9_Layout = delay(?wf1 VT("/A<0>") ?value1 0.55 ?edge1 "falling" ?nth1 2 ?td1 0.0 ?tol1 nil ?wf2 VT("/P<9>") ?value2 0.55 ?edge2 "rising" ?nth2 2 ?tol2 nil ?td2 nil ?stop nil ?multiple nil) (unticked)
  Output Energy_Vdd_Layout = integ((IT("/I0/Vdd") * VT("/vdd!")) 1.2e-08 1.53e-08 " ") (unticked)
  Signals: /A<7:0> as Input_A, /B<7:0> as Input_B, /P<15:0> as Product_P, /vdd!, /I0/A<0> (terminal), /I0/A<1> (terminal), /I0/A<2> (terminal), /I0/A<3> (terminal), /I0/A<4> (terminal), /I0/A<5> (terminal), /I0/A<6> (terminal), /I0/A<7> (terminal), /I0/B<0> (terminal), /I0/B<1> (terminal), /I0/B<2> (terminal), /I0/B<3> (terminal), /I0/B<4> (terminal), /I0/B<5> (terminal), /I0/B<6> (terminal), /I0/B<7> (terminal)
Run mode: Single Run, Sweeps and Corners
