ADE simulation setup
Run mode: Single Run, Sweeps and Corners
Tests:
  Project_xor_gate_tb_1: Project/xor_gate_tb/schematic, simulator spectre
    Variables: wn = 300n; wp = 300n
    Outputs: tphl_B_rises_A_fix1; tplh_B_falls_A_fix1; tphl_A_rises_B_fix1; tphl_A_falls_B_fix1; tphh_A_rises_B_fix0; tphh_A_falls_B_fix0; tphh_B_rises_A_fix0; tphh_B_falls_A_fix0
