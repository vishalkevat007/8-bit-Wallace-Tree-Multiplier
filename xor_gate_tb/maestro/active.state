ADE simulation setup
Test Project_xor_gate_tb_1: Project/xor_gate_tb/schematic, simulator spectre
  Models: /package/eda/cadence/gpdk045/gpdk045_v_6_0/gpdk045/../models/spectre/gpdk045.scs[tt]
  Variables: wn = 300n; wp = 300n
  Temperature: 27
  Stimulus vdd!: voltage dc dc=1.1
  Stimulus A: voltage pulse dc=1.1 val0=0 val1=1.1 period=2n rise=30p fall=30p width=1n
  Stimulus B: voltage dc dc=1.1
  Analysis tran: stop=5n
  Output tphl_B_rises_A_fix1 = delay(?wf1 VT("/B") ?value1 0.55 ?edge1 "rising" ?nth1 1 ?td1 0.0 ?tol1 nil ?wf2 VT("/Out") ?value2 0.55 ?edge2 "falling" ?nth2 1 ?tol2 nil ?td2 nil ?stop nil ?multiple nil)
  Output tplh_B_falls_A_fix1 = delay(?wf1 VT("/B") ?value1 0.55 ?edge1 "falling" ?nth1 1 ?td1 0.0 ?tol1 nil ?wf2 VT("/Out") ?value2 0.55 ?edge2 "rising" ?nth2 1 ?tol2 nil ?td2 nil ?stop nil ?multiple nil)
  Output tphh_B_rises_A_fix0 = delay(?wf1 VT("/B") ?value1 0.55 ?edge1 "rising" ?nth1 1 ?td1 0.0 ?tol1 nil ?wf2 VT("/Out") ?value2 0.55 ?edge2 "rising" ?nth2 1 ?tol2 nil ?td2 nil ?stop nil ?multiple nil)
  Output tphh_B_falls_A_fix0 = delay(?wf1 VT("/B") ?value1 0.55 ?edge1 "falling" ?nth1 1 ?td1 0.0 ?tol1 nil ?wf2 VT("/Out") ?value2 0.55 ?edge2 "falling" ?nth2 1 ?tol2 nil ?td2 nil ?stop nil ?multiple nil)
  Output tphl_A_rises_B_fix1 = delay(?wf1 VT("/A") ?value1 0.55 ?edge1 "rising" ?nth1 1 ?td1 0.0 ?tol1 nil ?wf2 VT("/Out") ?value2 0.55 ?edge2 "falling" ?nth2 1 ?tol2 nil ?td2 nil ?stop nil ?multiple nil)
  Output tphl_A_falls_B_fix1 = delay(?wf1 VT("/A") ?value1 0.55 ?edge1 "falling" ?nth1 1 ?td1 0.0 ?tol1 nil ?wf2 VT("/Out") ?value2 0.55 ?edge2 "rising" ?nth2 1 ?tol2 nil ?td2 nil ?stop nil ?multiple nil)
  Output tphh_A_rises_B_fix0 = delay(?wf1 VT("/A") ?value1 0.55 ?edge1 "rising" ?nth1 1 ?td1 0.0 ?tol1 nil ?wf2 VT("/Out") ?value2 0.55 ?edge2 "rising" ?nth2 1 ?tol2 nil ?td2 nil ?stop nil ?multiple nil)
  Output tphh_A_falls_B_fix0 = delay(?wf1 VT("/A") ?value1 0.55 ?edge1 "falling" ?nth1 1 ?td1 0.0 ?tol1 nil ?wf2 VT("/Out") ?value2 0.55 ?edge2 "falling" ?nth2 1 ?tol2 nil ?td2 nil ?stop nil ?multiple nil)
  Signals: /A, /B, /Out
Run mode: Single Run, Sweeps and Corners
