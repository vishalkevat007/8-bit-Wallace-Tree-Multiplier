ADE simulation setup
Test Project_accumulator_tb_1: Project/accumulator_tb/schematic, simulator spectre
  Models: /package/eda/cadence/gpdk045/gpdk045_v_6_0/gpdk045/../models/spectre/gpdk045.scs[tt]
  Temperature: 27
  Stimulus Clk: voltage bit val1=1.1 val0=0 rise=1p fall=1p period=1n data=01010101 rpttimes=-1
  Stimulus Reset: voltage bit val1=1.1 val0=0 rise=50p fall=50p period=4n data=000001111100 rpttimes=-1
  Stimulus Vdd: voltage dc dc=1.1
  Stimulus D<0>: voltage bit val1=1.1 val0=0 rise=50p fall=50p period=4n data=1101011 rpttimes=-1
  Stimulus D<1>: voltage bit val1=1.1 val0=0 rise=50p fall=50p period=4n data=10101 rpttimes=-1
  Stimulus D<2>: voltage bit val1=1.1 val0=0 rise=50p fall=50p period=4n data=010101 rpttimes=-1
  Stimulus D<3>: voltage bit val1=1.1 val0=0 rise=50p fall=50p period=4n data=0010110 rpttimes=-1
  Stimulus D<4>: voltage bit val1=1.1 val0=0 rise=50p fall=50p period=4n data=0001110110 rpttimes=-1
  Stimulus D<5>: voltage bit val1=1.1 val0=0 rise=50p fall=50p period=4n data=101011101 rpttimes=-1
  Stimulus D<6>: voltage bit val1=1.1 val0=0 rise=50p fall=50p period=4n data=101011101 rpttimes=-1
  Stimulus D<7>: voltage bit val1=1.1 val0=0 rise=50p fall=50p period=4n data=101101 rpttimes=-1
  Stimulus D<8>: voltage bit val1=1.1 val0=0 rise=50p fall=50p period=4n data=1101110 rpttimes=-1
  Stimulus D<9>: voltage bit val1=1.1 val0=0 rise=50p fall=50p period=4n data=0001010 rpttimes=-1
  Stimulus D<10>: voltage bit val1=1.1 val0=0 rise=50p fall=50p period=4n data=1001001 rpttimes=-1
  Stimulus D<11>: voltage bit val1=1.1 val0=0 rise=50p fall=50p period=4n data=10011111 rpttimes=-1
  Stimulus D<12>: voltage bit val1=1.1 val0=0 rise=50p fall=50p period=4n data=001101 rpttimes=-1
  Stimulus D<13>: voltage bit val1=1.1 val0=0 rise=50p fall=50p period=4n data=0100010 rpttimes=-1
  Stimulus D<14>: voltage bit val1=1.1 val0=0 rise=50p fall=50p period=4n data=0100101 rpttimes=-1
  Stimulus D<15>: voltage bit val1=1.1 val0=0 rise=50p fall=50p period=4n data=0100101 rpttimes=-1
  Stimulus D<16>: voltage bit val1=1.1 val0=0 rise=50p fall=50p period=4n data=0100101 rpttimes=-1
  Analysis tran: stop=28n
  Signals: /D<16:0>, /Clk, /Reset, /Q<16:0>
Run mode: Single Run, Sweeps and Corners
