ADE simulation setup
Run mode: Single Run, Sweeps and Corners
Tests:
  Project_accumulator_tb_1: Project/accumulator_tb/schematic, simulator spectre
    Outputs: /Q<16:0>; /D<16:0>
