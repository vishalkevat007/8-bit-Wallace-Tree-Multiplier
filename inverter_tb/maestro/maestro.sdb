ADE simulation setup
Run mode: Single Run, Sweeps and Corners
Tests:
  Project_inverter_tb_1: Project/inverter_tb/schematic, simulator spectre
