ADE simulation setup
Run mode: Single Run, Sweeps and Corners
Tests:
  Project_DFF_tb_1: Project/DFF_tb/schematic, simulator spectre
