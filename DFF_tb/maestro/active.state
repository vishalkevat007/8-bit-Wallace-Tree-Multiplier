ADE simulation setup
Test Project_DFF_tb_1: Project/DFF_tb/schematic, simulator spectre
  Models: /package/eda/cadence/gpdk045/gpdk045_v_6_0/gpdk045/../models/spectre/gpdk045.scs[tt]
  Temperature: 27
  Stimulus D: voltage bit val1=1.1 val0=0 rise=50p fall=50p period=2n data=111011100 rpttimes=-1
  Stimulus Clk: voltage bit rise=1p fall=1p period=1n data=01010101 rpttimes=-1
  Stimulus R: voltage bit val1=1.1 val0=0 rise=50p fall=50p period=2n data=000000111111 rpttimes=-1
  Stimulus Vdd: voltage dc dc=1.1
  Analysis tran: stop=28n
  Signals: /D, /Clk, /R, /Q
Run mode: Single Run, Sweeps and Corners
