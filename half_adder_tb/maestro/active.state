ADE simulation setup
Test Project_half_adder_tb_1: Project/half_adder_tb/schematic, simulator spectre
  Models: /package/eda/cadence/gpdk045/gpdk045_v_6_0/gpdk045/../models/spectre/gpdk045.scs[tt]
  Temperature: 27
  Stimulus vdd!: voltage dc dc=1.1
  Stimulus A: voltage pulse val0=0 val1=1.1 period=2n rise=50p fall=50p width=1n
  Stimulus B: voltage pulse val0=0 val1=1.1 period=2n delay=500.0p rise=50p fall=50p width=1n
  Analysis tran: stop=10n
  Signals: /A, /B, /Sum, /Carry
Run mode: Single Run, Sweeps and Corners
