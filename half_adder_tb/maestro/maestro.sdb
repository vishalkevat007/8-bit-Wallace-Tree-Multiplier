ADE simulation setup
Run mode: Single Run, Sweeps and Corners
Tests:
  Project_half_adder_tb_1: Project/half_adder_tb/schematic, simulator spectre
