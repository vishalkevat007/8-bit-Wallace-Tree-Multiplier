ADE simulation setup
Run mode: Single Run, Sweeps and Corners
Tests:
  Project_MAC_tb_1: Project/MAC_tb/schematic, simulator spectre
    Outputs: "/A<7:0>"; "/f"; Input_B; Output_Q; Input_A
