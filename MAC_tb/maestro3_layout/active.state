ADE simulation setup
Test Project_MAC_tb_1: Project/MAC_tb/config, simulator spectre
  Models: /package/eda/cadence/gpdk045/gpdk045_v_6_0/gpdk045/../models/spectre/gpdk045.scs[tt]
  Temperature: 27
  Stimulus A<0>: voltage bit val1=1.1 val0=0 rise=50p fall=50p period=8n data=1101 rpttimes=-1
  Stimulus A<1>: voltage bit val1=1.1 val0=0 rise=50p fall=50p period=8n data=1011 rpttimes=-1
  Stimulus A<2>: voltage bit val1=1.1 val0=0 rise=50p fall=50p period=8n data=1110 rpttimes=-1
  Stimulus A<3>: voltage bit val1=1.1 val0=0 rise=50p fall=50p period=8n data=1101 rpttimes=-1
  Stimulus A<4>: voltage bit val1=1.1 val0=0 rise=50p fall=50p period=8n data=1110 rpttimes=-1
  Stimulus A<5>: voltage bit val1=1.1 val0=0 rise=50p fall=50p period=8n data=1010 rpttimes=-1
  Stimulus A<6>: voltage bit val1=1.1 val0=0 rise=50p fall=50p period=8n data=1001 rpttimes=-1
  Stimulus A<7>: voltage bit val1=1.1 val0=0 rise=50p fall=50p period=8n data=1101 rpttimes=-1
  Stimulus B<0>: voltage bit val1=1.1 val0=0 rise=50p fall=50p period=8n data=1010 rpttimes=-1
  Stimulus B<1>: voltage bit val1=1.1 val0=0 rise=50p fall=50p period=8n data=1011 rpttimes=-1
  Stimulus B<2>: voltage bit val1=1.1 val0=0 rise=50p fall=50p period=8n data=1101 rpttimes=-1
  Stimulus B<3>: voltage bit val1=1.1 val0=0 rise=50p fall=50p period=8n data=1110 rpttimes=-1
  Stimulus B<4>: voltage bit val1=1.1 val0=0 rise=50p fall=50p period=8n data=1100 rpttimes=-1
  Stimulus B<5>: voltage bit val1=1.1 val0=0 rise=50p fall=50p period=8n data=1010 rpttimes=-1
  Stimulus B<6>: voltage bit val1=1.1 val0=0 rise=50p fall=50p period=8n data=1001 rpttimes=-1
  Stimulus B<7>: voltage bit val1=1.1 val0=0 rise=50p fall=50p period=8n data=1110 rpttimes=-1
  Stimulus Clk: voltage bit val1=1.1 val0=0 rise=1p fall=1p period=1n data=00010000 rpttimes=-1
  Stimulus Reset: voltage bit val1=1.1 val0=0 delay=0 rise=1p fall=1p period=1n data=1000000000000000 rpttimes=-1
  Stimulus vdd!: voltage dc dc=1.1
  Analysis tran: stop=20n
  Output Energy = integ((IT("/I1/Vdd") * VT("/vdd!")) 8e-09 1.3e-08 " ")
  Signals: /A<7:0> as Input_A, /B<7:0> as Input_B, /vdd! as Source_Voltage, /I1/Vdd (terminal) as Source_Current, /Clk as Clock, /Reset as Reset, /Q<16:0> as Output_Q
Run mode: Single Run, Sweeps and Corners
