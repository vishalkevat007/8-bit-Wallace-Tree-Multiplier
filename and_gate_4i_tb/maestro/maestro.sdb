ADE simulation setup
Run mode: Single Run, Sweeps and Corners
Tests:
  Project_and_gate_4i_tb_1: Project/and_gate_4i_tb/schematic, simulator spectre
