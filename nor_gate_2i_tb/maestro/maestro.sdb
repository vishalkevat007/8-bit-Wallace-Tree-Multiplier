ADE simulation setup
Run mode: Single Run, Sweeps and Corners
Tests:
  Project_nor_gate_2i_tb_1: Project/nor_gate_2i_tb/schematic, simulator spectre
