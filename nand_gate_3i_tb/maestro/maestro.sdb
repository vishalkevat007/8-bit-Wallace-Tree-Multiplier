ADE simulation setup
Run mode: Single Run, Sweeps and Corners
Tests:
  Project_nand_gate_3i_tb_1: Project/nand_gate_3i_tb/schematic, simulator spectre
