ADE simulation setup
Test Project_compressor_4_2_tb_1: Project/compressor_4_2_tb/schematic, simulator spectre
  Models: /package/eda/cadence/gpdk045/gpdk045_v_6_0/gpdk045/../models/spectre/gpdk045.scs[tt]
  Temperature: 27
  Stimulus A1: voltage bit val1=1.1 val0=0 rise=30p fall=30p period=2n data=010111 rpttimes=-1
  Stimulus A2: voltage bit val1=1.1 val0=0 rise=30p fall=30p period=2n data=011010 rpttimes=-1
  Stimulus A3: voltage bit val1=1.1 val0=0 rise=30p fall=30p period=2n data=010101 rpttimes=-1
  Stimulus A4: voltage bit val1=1.1 val0=0 rise=30p fall=30p period=2n data=010101 rpttimes=-1
  Stimulus Cin: voltage bit val1=1.1 val0=0 rise=30p fall=30p period=2n data=101011 rpttimes=-1
  Stimulus vdd!: voltage dc dc=1.1
  Analysis tran: stop=20n
  Signals: /A1, /A2, /A3, /A4, /Cin, /Sum, /Carry, /Cout
Run mode: Single Run, Sweeps and Corners
