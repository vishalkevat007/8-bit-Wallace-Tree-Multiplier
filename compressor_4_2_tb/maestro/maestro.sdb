ADE simulation setup
Run mode: Single Run, Sweeps and Corners
Tests:
  Project_compressor_4_2_tb_1: Project/compressor_4_2_tb/schematic, simulator spectre
