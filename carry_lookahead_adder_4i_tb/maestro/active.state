ADE simulation setup
Test Project_carry_lookahead_adder_tb_1: Project/carry_lookahead_adder_4i_tb/schematic, simulator spectre
  Models: /package/eda/cadence/gpdk045/gpdk045_v_6_0/gpdk045/../models/spectre/gpdk045.scs[tt]
  Temperature: 27
  Stimulus A1: voltage bit val1=1.1 val0=0 rise=50p fall=50p period=2n data=1010 rpttimes=-1
  Stimulus A0: voltage bit val1=1.1 val0=0 rise=50p fall=50p period=2n data=0011 rpttimes=-1
  Stimulus A2: voltage bit val1=1.1 val0=0 rise=50p fall=50p period=2n data=1110 rpttimes=-1
  Stimulus A3: voltage bit val1=1.1 val0=0 rise=50p fall=50p period=2n data=0001 rpttimes=-1
  Stimulus B0: voltage bit val1=1.1 val0=0 rise=50p fall=50p period=2n data=0101 rpttimes=-1
  Stimulus B1: voltage bit val1=1.1 val0=0 rise=50p fall=50p period=2n data=0010 rpttimes=-1
  Stimulus B2: voltage bit val1=1.1 val0=0 rise=50p fall=50p period=2n data=1111 rpttimes=-1
  Stimulus B3: voltage bit val1=1.1 val0=0 rise=50p fall=50p period=2n data=0110 rpttimes=-1
  Stimulus C0: voltage dc dc=1.1
  Stimulus vdd!: voltage dc dc=1.1
  Analysis tran: stop=17n
  Signals: /C0, /A0, /B0, /A1, /B1, /A2, /B2, /A3, /B3, /S0, /S1, /S2, /S3, /C4
Run mode: Single Run, Sweeps and Corners
