ADE simulation setup
Run mode: Single Run, Sweeps and Corners
Tests:
  Project_carry_lookahead_adder_tb_1: Project/carry_lookahead_adder_4i_tb/schematic, simulator spectre
    Outputs: "/I0/G0"; /A1; /B1
